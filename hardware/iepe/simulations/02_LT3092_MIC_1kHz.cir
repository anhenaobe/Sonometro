* LT3092 REAL DE ADI - emulador IEPE 12.5 V DC + 50 mVpk a 1 kHz
* No es un modelo acustico certificado del ROGA RG-50
.param VSUP=24
V1 VCC 0 {VSUP}
XU1 VCC SET REG LT3092
RSET SET IEPE 20k
ROUT REG IEPE 71.5
RMIC IEPE MIC 50
VMIC MIC 0 SINE(12.5 0.05 1k)
CCABLE IEPE 0 1n
.tran 0 25m 10m 1u
.meas TRAN IAVG AVG I(RMIC) FROM=15m TO=25m
.meas TRAN IMAX MAX I(RMIC) FROM=15m TO=25m
.meas TRAN IMIN MIN I(RMIC) FROM=15m TO=25m
.meas TRAN VMAX MAX V(IEPE) FROM=15m TO=25m
.meas TRAN VMIN MIN V(IEPE) FROM=15m TO=25m
.end
