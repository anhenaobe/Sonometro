* OPA192 (modelo TI real) + BSS84 (modelo Diodes Inc real)
* REQUIERE 2 ficheros del fabricante en carpeta: OPA192.lib y BSS84.spice.txt.
* Incluye referencia flotante IDEAL de 2.5 V: NO valida la referencia fisica.
* PINES: OPA192 IN+ IN- VCC VEE OUT ; BSS84 D G S
.include OPA192.lib
.include BSS84.spice.txt
.param VSUP=24
VCC VCC 0 {VSUP}
VREF25 VCC VZ 2.5
RBLEED VZ 0 22k
RTOP VCC REF 1k
RBOTTOM REF VZ 7.93k
RSENSE VCC SRC 100
XQ1 IEPE GATE SRC BSS84
RGS SRC GATE 100k
DGS GATE SRC DZ12
.model DZ12 D(BV=12 IBV=1m RS=3)
XU1 REF SRC VCC 0 DRIVE OPA192
RGATE DRIVE GATE 1k
CGATE GATE SRC 100p
RMIC IEPE MIC 50
VMIC MIC 0 SINE(12.5 0.05 1k)
CCABLE IEPE 0 1n
.tran 0 30m 10m 1u
.meas TRAN IAVG AVG I(RMIC) FROM=20m TO=30m
.meas TRAN IMAX MAX I(RMIC) FROM=20m TO=30m
.meas TRAN IMIN MIN I(RMIC) FROM=20m TO=30m
.meas TRAN VMAX MAX V(IEPE) FROM=20m TO=30m
.meas TRAN VMIN MIN V(IEPE) FROM=20m TO=30m
.meas TRAN VGS_MAX MAX V(GATE,SRC) FROM=20m TO=30m
.meas TRAN VGS_MIN MIN V(GATE,SRC) FROM=20m TO=30m
.end
