* 03 - Transitorio: barrido logaritmico 20 Hz -> 20 kHz en 1 s (50 mV pico)
* La frecuencia cambia continuamente y cada vez mas rapido (como una voz que
* sube de tono, pero cubriendo TODA la banda). Se compara la entrada acustica
* con lo que ve el ADC en las tres variantes.
*   f(t) = 20 Hz * 1000^(t/1 s) ;  fase(t) = 2*pi*20*T/ln(1000) * (1000^(t/T) - 1)
.include circuito.inc

Bsig sig 0 V = 0.05*sin(18.19156*(exp(6.907755*time) - 1))

.options interp
.tran 5u 1 0 2u

.control
set wr_singlescale
set wr_vecnames
option numdgt=8
run
wrdata resultados/tran_barrido.txt v(sig) v(adcA) v(adcB) v(adcC)
.endc
.end
